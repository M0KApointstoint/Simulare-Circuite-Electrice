Circuit 1
* Mocanu Cristian-Lucian, 314CB
Vin 1 0 AC 1 0
R1 1 2 10
L1 2 0 0.01
*
.AC LIN 1 100 100
.PRINT AC IM(R1) IP(R1) IR(R1) II(R1)
.END
