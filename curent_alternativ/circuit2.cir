Circuit 2
* Mocanu Cristian-Lucian, 314CB
Vin 1 0 AC 1 0
R1 2 0 10
C1 1 2 0.0001
*
.AC LIN 1 318 318
.PRINT AC IM(R1) IP(R1) IR(R1) II(R1)
.END
