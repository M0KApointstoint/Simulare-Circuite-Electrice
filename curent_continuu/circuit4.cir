Circuit 4
* Mocanu Cristian-Lucian, 314CB
V1 2 1 12
V3 6 5 4
VCom 0 1 0
H2 4 6 VCom 2
I4 3 0 4
R1 2 3 2
R2 3 4 1
R3 3 5 4
R5 0 6 2
*
.DC V1 12 12 1
.PRINT DC I(R1) I(R2) I(R3) I(R5) V(I4)
.OP
.END
