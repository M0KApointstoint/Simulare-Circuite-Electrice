Circuit 2
* Mocanu Cristian-Lucian, 314CB
V1 2 0 90
V2 0 6 20
V3 4 5 20
I1 3 1 5
R1 1 6 20
R2 2 3 5
R3 5 3 2
R4 5 0 5
R5 4 1 10
*
.DC V1 90 90 1
.PRINT DC I(R1) I(R2) I(R3) I(R4) I(R5) V(I1)
.END
