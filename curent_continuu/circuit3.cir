Circuit 3
* Mocanu Cristian-Lucian, 314CB
V1 4 0 90
V2 1 0 50
V3 2 1 30
I1 4 5 6
R1 4 3 25
R2 5 0 12
R3 2 3 20
R4 3 0 10
R5 1 5 10
*
.DC V1 90 90 1
.PRINT DC I(R1) I(R2) I(R3) I(R4) I(R5) V(I1)
.OP
.END
