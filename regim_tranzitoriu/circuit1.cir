Circuit 1 Conditii Initiale
* Mocanu Cristian-Lucian, 314CB
V1 2 1 90
R1 1 0 5
R2 3 0 10
L 3 0 0.0625
C 2 3 0.0001
*
.DC LIN V1 90 90 1
.PRINT DC V(2, 3) I(L)
.END
