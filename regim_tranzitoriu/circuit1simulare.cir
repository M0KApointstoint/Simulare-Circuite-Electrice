Circuit 1 Simulare
* Mocanu Cristian-Lucian, 314CB
R 3 0 10
L 3 0 0.0625 IC=0
C 0 3 0.0001 IC=90
*
.TRAN 0.5ms 20ms UIC
.PROBE
.END
